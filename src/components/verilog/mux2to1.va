//   Qucs analogue mux2to1 model
//   The structure and theoretical background to the mux2to1
//   Verilog-a model are presented in the Qucs digital tutorial.
//
//   This is free software; you can redistribute it and/or modify
//   it under the terms of the GNU General Public License as published by
//   the Free Software Foundation; either version 2, or (at your option)
//   any later version.
//
//   Copyright (C), Mike Brinson, mbrin72043@yahoo.co.uk, November 2008.
//
`include "disciplines.vams"
`include "constants.vams"

`ifdef insideADMS
`define attr(txt) (*txt*)
`else
`define attr(txt)
`endif

module mux2to1 (EN, A, D0, D1, Y);
 inout EN, A, D0, D1, Y;
 electrical EN, A, D0, D1, Y;
 electrical n1, n2;

 parameter real TR=6 from [1.0:20.0] `attr(info="transfer function high scaling factor");
 parameter real Delay = 1e-9 from [0: inf] `attr(info="output delay" unit="s");
//
 real Rd, Ccc, In1;
//
analog begin
@(initial_model)
  begin
    Rd = 1e3;
    Ccc= Delay*1.43/Rd;
  end
In1 = (1-V(EN))*(V(D1)*V(A)+V(D0)*(1-V(A)));
I(n1) <+ -0.5*(1+tanh(TR*(In1-0.5)));
I(n1) <+ V(n1);
I(n1, n2) <+ V(n1,n2)/Rd;
I(n2) <+ ddt(Ccc*V(n2));
I(Y)  <+ -V(n2);
I(Y) <+ V(Y);
end
endmodule
